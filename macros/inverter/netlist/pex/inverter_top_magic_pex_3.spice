* PEX produced on Wed Aug 26 05:33:52 PM CEST 2026 using /foss/tools/sak/sak-pex.sh with m=3 and s=1 (extresist threshold=10000 mOhm, minres=1000 mOhm, mindelay=1 ps)
* NGSPICE file created from inverter_top_pex.ext - technology: ihp-sg13g2

.subckt inverter_top_pex VDD vin4 vout4 VSS vin3 vout3 vin2 vout2 vout1 vin1
X0 vout3 vin3 VSS.t105 VSS.t86 sg13_lv_nmos ad=0.19p pd=1.38u as=0.19p ps=1.38u w=1u l=1u
X1 VDD VDD VDD VDD sg13_lv_pmos ad=1.14p pd=6.38u as=0.56797n ps=1.006m w=6u l=1u
X2 VSS.t1 VSS.t53 VSS.t55 VSS.t54 sg13_lv_nmos ad=0.34p pd=2.68u as=0 ps=0 w=1u l=1u
X3 VDD VDD VDD VDD sg13_lv_pmos ad=1.14p pd=6.38u as=0 ps=0 w=6u l=1u
X4 VDD vin4 vout4 VDD sg13_lv_pmos ad=1.14p pd=6.38u as=1.14p ps=6.38u w=6u l=1u
X5 vout2 vin2 VSS.t76 VSS.t77 sg13_lv_nmos ad=0.19p pd=1.38u as=0.19p ps=1.38u w=1u l=1u
X6 vout3 vin3 VDD VDD sg13_lv_pmos ad=1.14p pd=6.38u as=1.14p ps=6.38u w=6u l=1u
X7 vout4 vin4 VSS.t110 VSS.t111 sg13_lv_nmos ad=0.19p pd=1.38u as=0.19p ps=1.38u w=1u l=1u
X8 vout3 vin3 VSS.t42 VSS.t59 sg13_lv_nmos ad=0.19p pd=1.38u as=0.19p ps=1.38u w=1u l=1u
X9 vout2 vin2 VSS.t70 VSS.t71 sg13_lv_nmos ad=0.19p pd=1.38u as=0.19p ps=1.38u w=1u l=1u
X10 vout4 vin4 VDD VDD sg13_lv_pmos ad=1.14p pd=6.38u as=1.14p ps=6.38u w=6u l=1u
X11 VDD vin2 vout2 VDD sg13_lv_pmos ad=1.14p pd=6.38u as=1.14p ps=6.38u w=6u l=1u
X12 VSS.t76 vin2 vout2 VSS.t75 sg13_lv_nmos ad=0.19p pd=1.38u as=0.19p ps=1.38u w=1u l=1u
X13 vout2 vin2 VSS.t79 VSS.t80 sg13_lv_nmos ad=0.19p pd=1.38u as=0.19p ps=1.38u w=1u l=1u
X14 vout2 vin2 VDD VDD sg13_lv_pmos ad=1.14p pd=6.38u as=1.14p ps=6.38u w=6u l=1u
X15 VSS.t116 vin4 vout4 VSS.t115 sg13_lv_nmos ad=0.19p pd=1.38u as=0.19p ps=1.38u w=1u l=1u
X16 vout1 vin1 VSS.t24 VSS.t25 sg13_lv_nmos ad=0.19p pd=1.38u as=0.19p ps=1.38u w=1u l=1u
X17 VDD vin2 vout2 VDD sg13_lv_pmos ad=1.14p pd=6.38u as=1.14p ps=6.38u w=6u l=1u
X18 vout4 vin4 VSS.t34 VSS.t108 sg13_lv_nmos ad=0.19p pd=1.38u as=0.19p ps=1.38u w=1u l=1u
X19 VDD vin2 vout2 VDD sg13_lv_pmos ad=1.14p pd=6.38u as=1.14p ps=6.38u w=6u l=1u
X20 VSS.t105 vin3 vout3 VSS.t84 sg13_lv_nmos ad=0.19p pd=1.38u as=0.19p ps=1.38u w=1u l=1u
X21 vout4 vin4 VSS.t125 VSS.t126 sg13_lv_nmos ad=0.19p pd=1.38u as=0.19p ps=1.38u w=1u l=1u
X22 VSS.t119 vin4 vout4 VSS.t118 sg13_lv_nmos ad=0.19p pd=1.38u as=0.19p ps=1.38u w=1u l=1u
X23 VDD vin3 vout3 VDD sg13_lv_pmos ad=1.14p pd=6.38u as=1.14p ps=6.38u w=6u l=1u
X24 VDD vin2 vout2 VDD sg13_lv_pmos ad=1.14p pd=6.38u as=1.14p ps=6.38u w=6u l=1u
X25 vout3 vin3 VDD VDD sg13_lv_pmos ad=1.14p pd=6.38u as=1.14p ps=6.38u w=6u l=1u
X26 VSS.t70 vin2 vout2 VSS.t69 sg13_lv_nmos ad=0.19p pd=1.38u as=0.19p ps=1.38u w=1u l=1u
X27 VDD vin3 vout3 VDD sg13_lv_pmos ad=1.14p pd=6.38u as=1.14p ps=6.38u w=6u l=1u
X28 VSS.t42 VSS.t39 VSS.t41 VSS.t40 sg13_lv_nmos ad=0.34p pd=2.68u as=0 ps=0 w=1u l=1u
X29 vout2 vin2 VDD VDD sg13_lv_pmos ad=1.14p pd=6.38u as=1.14p ps=6.38u w=6u l=1u
X30 vout2 vin2 VSS.t73 VSS.t74 sg13_lv_nmos ad=0.19p pd=1.38u as=0.19p ps=1.38u w=1u l=1u
X31 vout1 vin1 VSS.t18 VSS.t19 sg13_lv_nmos ad=0.19p pd=1.38u as=0.19p ps=1.38u w=1u l=1u
X32 VSS.t79 vin2 vout2 VSS.t78 sg13_lv_nmos ad=0.19p pd=1.38u as=0.19p ps=1.38u w=1u l=1u
X33 vout4 vin4 VSS.t122 VSS.t123 sg13_lv_nmos ad=0.19p pd=1.38u as=0.19p ps=1.38u w=1u l=1u
X34 vout1 vin1 VDD VDD sg13_lv_pmos ad=1.14p pd=6.38u as=1.14p ps=6.38u w=6u l=1u
X35 vout1 vin1 VSS.t12 VSS.t13 sg13_lv_nmos ad=0.19p pd=1.38u as=0.19p ps=1.38u w=1u l=1u
X36 VSS.t128 vin4 vout4 VSS.t127 sg13_lv_nmos ad=0.19p pd=1.38u as=0.19p ps=1.38u w=1u l=1u
X37 VDD VDD VDD VDD sg13_lv_pmos ad=1.14p pd=6.38u as=0 ps=0 w=6u l=1u
X38 VSS.t18 vin1 vout1 VSS.t17 sg13_lv_nmos ad=0.19p pd=1.38u as=0.19p ps=1.38u w=1u l=1u
X39 vout2 vin2 VDD VDD sg13_lv_pmos ad=1.14p pd=6.38u as=1.14p ps=6.38u w=6u l=1u
X40 VDD vin4 vout4 VDD sg13_lv_pmos ad=1.14p pd=6.38u as=1.14p ps=6.38u w=6u l=1u
X41 vout1 vin1 VSS.t21 VSS.t22 sg13_lv_nmos ad=0.19p pd=1.38u as=0.19p ps=1.38u w=1u l=1u
X42 vout3 vin3 VSS.t103 VSS.t83 sg13_lv_nmos ad=0.19p pd=1.38u as=0.19p ps=1.38u w=1u l=1u
X43 VDD vin3 vout3 VDD sg13_lv_pmos ad=1.14p pd=6.38u as=1.14p ps=6.38u w=6u l=1u
X44 vout4 vin4 VDD VDD sg13_lv_pmos ad=1.14p pd=6.38u as=1.14p ps=6.38u w=6u l=1u
X45 VDD vin4 vout4 VDD sg13_lv_pmos ad=1.14p pd=6.38u as=1.14p ps=6.38u w=6u l=1u
X46 vout3 vin3 VDD VDD sg13_lv_pmos ad=1.14p pd=6.38u as=1.14p ps=6.38u w=6u l=1u
X47 VDD vin3 vout3 VDD sg13_lv_pmos ad=1.14p pd=6.38u as=1.14p ps=6.38u w=6u l=1u
X48 VSS.t38 VSS.t35 VSS.t37 VSS.t36 sg13_lv_nmos ad=0.19p pd=1.38u as=0 ps=0 w=1u l=1u
X49 VDD vin4 vout4 VDD sg13_lv_pmos ad=1.14p pd=6.38u as=1.14p ps=6.38u w=6u l=1u
X50 VDD vin2 vout2 VDD sg13_lv_pmos ad=1.14p pd=6.38u as=1.14p ps=6.38u w=6u l=1u
X51 VSS.t131 vin4 vout4 VSS.t130 sg13_lv_nmos ad=0.19p pd=1.38u as=0.19p ps=1.38u w=1u l=1u
X52 VDD vin3 vout3 VDD sg13_lv_pmos ad=1.14p pd=6.38u as=1.14p ps=6.38u w=6u l=1u
X53 VSS.t12 vin1 vout1 VSS.t11 sg13_lv_nmos ad=0.19p pd=1.38u as=0.19p ps=1.38u w=1u l=1u
X54 VDD vin1 vout1 VDD sg13_lv_pmos ad=1.14p pd=6.38u as=1.14p ps=6.38u w=6u l=1u
X55 vout4 vin4 VSS.t134 VSS.t135 sg13_lv_nmos ad=0.19p pd=1.38u as=0.19p ps=1.38u w=1u l=1u
X56 vout1 vin1 VDD VDD sg13_lv_pmos ad=1.14p pd=6.38u as=1.14p ps=6.38u w=6u l=1u
X57 vout4 vin4 VDD VDD sg13_lv_pmos ad=1.14p pd=6.38u as=1.14p ps=6.38u w=6u l=1u
X58 vout1 vin1 VSS.t15 VSS.t16 sg13_lv_nmos ad=0.19p pd=1.38u as=0.19p ps=1.38u w=1u l=1u
X59 VDD vin1 vout1 VDD sg13_lv_pmos ad=1.14p pd=6.38u as=1.14p ps=6.38u w=6u l=1u
X60 vout3 vin3 VSS.t99 VSS.t77 sg13_lv_nmos ad=0.19p pd=1.38u as=0.19p ps=1.38u w=1u l=1u
X61 VSS.t21 vin1 vout1 VSS.t20 sg13_lv_nmos ad=0.19p pd=1.38u as=0.19p ps=1.38u w=1u l=1u
X62 VDD VDD VDD VDD sg13_lv_pmos ad=2.04p pd=12.68u as=0 ps=0 w=6u l=1u
X63 vout4 vin4 VDD VDD sg13_lv_pmos ad=1.14p pd=6.38u as=1.14p ps=6.38u w=6u l=1u
X64 VDD vin3 vout3 VDD sg13_lv_pmos ad=1.14p pd=6.38u as=1.14p ps=6.38u w=6u l=1u
X65 VDD vin4 vout4 VDD sg13_lv_pmos ad=1.14p pd=6.38u as=1.14p ps=6.38u w=6u l=1u
X66 vout3 vin3 VDD VDD sg13_lv_pmos ad=1.14p pd=6.38u as=1.14p ps=6.38u w=6u l=1u
X67 vout3 vin3 VSS.t95 VSS.t71 sg13_lv_nmos ad=0.19p pd=1.38u as=0.19p ps=1.38u w=1u l=1u
X68 VSS.t99 vin3 vout3 VSS.t75 sg13_lv_nmos ad=0.19p pd=1.38u as=0.19p ps=1.38u w=1u l=1u
X69 VDD VDD VDD VDD sg13_lv_pmos ad=1.14p pd=6.38u as=0 ps=0 w=6u l=1u
X70 vout3 vin3 VSS.t101 VSS.t80 sg13_lv_nmos ad=0.19p pd=1.38u as=0.19p ps=1.38u w=1u l=1u
X71 vout4 vin4 VDD VDD sg13_lv_pmos ad=1.14p pd=6.38u as=1.14p ps=6.38u w=6u l=1u
X72 vout3 vin3 VDD VDD sg13_lv_pmos ad=1.14p pd=6.38u as=1.14p ps=6.38u w=6u l=1u
X73 VDD vin1 vout1 VDD sg13_lv_pmos ad=1.14p pd=6.38u as=1.14p ps=6.38u w=6u l=1u
X74 vout2 vin2 VDD VDD sg13_lv_pmos ad=1.14p pd=6.38u as=1.14p ps=6.38u w=6u l=1u
X75 vout1 vin1 VDD VDD sg13_lv_pmos ad=1.14p pd=6.38u as=1.14p ps=6.38u w=6u l=1u
X76 vout2 vin2 VSS.t64 VSS.t65 sg13_lv_nmos ad=0.19p pd=1.38u as=0.19p ps=1.38u w=1u l=1u
X77 VDD vin1 vout1 VDD sg13_lv_pmos ad=1.14p pd=6.38u as=1.14p ps=6.38u w=6u l=1u
X78 VDD vin1 vout1 VDD sg13_lv_pmos ad=1.14p pd=6.38u as=1.14p ps=6.38u w=6u l=1u
X79 VDD vin3 vout3 VDD sg13_lv_pmos ad=1.14p pd=6.38u as=1.14p ps=6.38u w=6u l=1u
X80 VSS.t95 vin3 vout3 VSS.t69 sg13_lv_nmos ad=0.19p pd=1.38u as=0.19p ps=1.38u w=1u l=1u
X81 vout3 vin3 VSS.t97 VSS.t74 sg13_lv_nmos ad=0.19p pd=1.38u as=0.19p ps=1.38u w=1u l=1u
X82 VSS.t113 vin4 vout4 VSS.t112 sg13_lv_nmos ad=0.19p pd=1.38u as=0.19p ps=1.38u w=1u l=1u
X83 VDD vin4 vout4 VDD sg13_lv_pmos ad=1.14p pd=6.38u as=1.14p ps=6.38u w=6u l=1u
X84 VSS.t101 vin3 vout3 VSS.t78 sg13_lv_nmos ad=0.19p pd=1.38u as=0.19p ps=1.38u w=1u l=1u
X85 vout4 vin4 VSS.t116 VSS.t117 sg13_lv_nmos ad=0.19p pd=1.38u as=0.19p ps=1.38u w=1u l=1u
X86 VDD vin1 vout1 VDD sg13_lv_pmos ad=1.14p pd=6.38u as=1.14p ps=6.38u w=6u l=1u
X87 vout2 vin2 VDD VDD sg13_lv_pmos ad=1.14p pd=6.38u as=1.14p ps=6.38u w=6u l=1u
X88 vout1 vin1 VDD VDD sg13_lv_pmos ad=1.14p pd=6.38u as=1.14p ps=6.38u w=6u l=1u
X89 VSS.t110 vin4 vout4 VSS.t109 sg13_lv_nmos ad=0.19p pd=1.38u as=0.19p ps=1.38u w=1u l=1u
X90 VDD VDD VDD VDD sg13_lv_pmos ad=2.04p pd=12.68u as=0 ps=0 w=6u l=1u
X91 vout2 vin2 VDD VDD sg13_lv_pmos ad=1.14p pd=6.38u as=1.14p ps=6.38u w=6u l=1u
X92 VDD vin2 vout2 VDD sg13_lv_pmos ad=1.14p pd=6.38u as=1.14p ps=6.38u w=6u l=1u
X93 VSS.t64 vin2 vout2 VSS.t63 sg13_lv_nmos ad=0.19p pd=1.38u as=0.19p ps=1.38u w=1u l=1u
X94 VSS.t122 vin4 vout4 VSS.t121 sg13_lv_nmos ad=0.19p pd=1.38u as=0.19p ps=1.38u w=1u l=1u
X95 vout2 vin2 VDD VDD sg13_lv_pmos ad=1.14p pd=6.38u as=1.14p ps=6.38u w=6u l=1u
X96 VDD VDD VDD VDD sg13_lv_pmos ad=2.04p pd=12.68u as=0 ps=0 w=6u l=1u
X97 vout2 vin2 VSS.t67 VSS.t68 sg13_lv_nmos ad=0.19p pd=1.38u as=0.19p ps=1.38u w=1u l=1u
X98 VSS.t73 vin2 vout2 VSS.t72 sg13_lv_nmos ad=0.19p pd=1.38u as=0.19p ps=1.38u w=1u l=1u
X99 vout1 vin1 VDD VDD sg13_lv_pmos ad=1.14p pd=6.38u as=1.14p ps=6.38u w=6u l=1u
X100 vout1 vin1 VSS.t6 VSS.t7 sg13_lv_nmos ad=0.19p pd=1.38u as=0.19p ps=1.38u w=1u l=1u
X101 vout4 vin4 VSS.t119 VSS.t120 sg13_lv_nmos ad=0.19p pd=1.38u as=0.19p ps=1.38u w=1u l=1u
X102 vout3 vin3 VDD VDD sg13_lv_pmos ad=1.14p pd=6.38u as=1.14p ps=6.38u w=6u l=1u
X103 vout4 vin4 VSS.t131 VSS.t132 sg13_lv_nmos ad=0.19p pd=1.38u as=0.19p ps=1.38u w=1u l=1u
X104 VSS.t52 VSS.t50 VSS.t51 VSS.t44 sg13_lv_nmos ad=0.19p pd=1.38u as=0 ps=0 w=1u l=1u
X105 VSS.t125 vin4 vout4 VSS.t124 sg13_lv_nmos ad=0.19p pd=1.38u as=0.19p ps=1.38u w=1u l=1u
X106 VDD vin1 vout1 VDD sg13_lv_pmos ad=1.14p pd=6.38u as=1.14p ps=6.38u w=6u l=1u
X107 VSS.t51 vin2 vout2 VSS.t87 sg13_lv_nmos ad=0.19p pd=1.38u as=0.19p ps=1.38u w=1u l=1u
X108 VDD vin2 vout2 VDD sg13_lv_pmos ad=1.14p pd=6.38u as=1.14p ps=6.38u w=6u l=1u
X109 vout4 vin4 VSS.t128 VSS.t129 sg13_lv_nmos ad=0.19p pd=1.38u as=0.19p ps=1.38u w=1u l=1u
X110 vout4 vin4 VDD VDD sg13_lv_pmos ad=1.14p pd=6.38u as=1.14p ps=6.38u w=6u l=1u
X111 vout2 vin2 VDD VDD sg13_lv_pmos ad=1.14p pd=6.38u as=1.14p ps=6.38u w=6u l=1u
X112 vout2 vin2 VSS.t61 VSS.t62 sg13_lv_nmos ad=0.19p pd=1.38u as=0.19p ps=1.38u w=1u l=1u
X113 VDD vin2 vout2 VDD sg13_lv_pmos ad=1.14p pd=6.38u as=1.14p ps=6.38u w=6u l=1u
X114 VSS.t67 vin2 vout2 VSS.t66 sg13_lv_nmos ad=0.19p pd=1.38u as=0.19p ps=1.38u w=1u l=1u
X115 VDD vin4 vout4 VDD sg13_lv_pmos ad=1.14p pd=6.38u as=1.14p ps=6.38u w=6u l=1u
X116 VDD VDD VDD VDD sg13_lv_pmos ad=2.04p pd=12.68u as=0 ps=0 w=6u l=1u
X117 VSS.t61 vin2 vout2 VSS.t60 sg13_lv_nmos ad=0.19p pd=1.38u as=0.19p ps=1.38u w=1u l=1u
X118 VSS.t6 vin1 vout1 VSS.t5 sg13_lv_nmos ad=0.19p pd=1.38u as=0.19p ps=1.38u w=1u l=1u
X119 vout3 vin3 VDD VDD sg13_lv_pmos ad=1.14p pd=6.38u as=1.14p ps=6.38u w=6u l=1u
X120 vout1 vin1 VSS.t9 VSS.t10 sg13_lv_nmos ad=0.19p pd=1.38u as=0.19p ps=1.38u w=1u l=1u
X121 VSS.t15 vin1 vout1 VSS.t14 sg13_lv_nmos ad=0.19p pd=1.38u as=0.19p ps=1.38u w=1u l=1u
X122 vout3 vin3 VDD VDD sg13_lv_pmos ad=1.14p pd=6.38u as=1.14p ps=6.38u w=6u l=1u
X123 VDD vin3 vout3 VDD sg13_lv_pmos ad=1.14p pd=6.38u as=1.14p ps=6.38u w=6u l=1u
X124 vout3 vin3 VDD VDD sg13_lv_pmos ad=1.14p pd=6.38u as=1.14p ps=6.38u w=6u l=1u
X125 vout3 vin3 VSS.t91 VSS.t65 sg13_lv_nmos ad=0.19p pd=1.38u as=0.19p ps=1.38u w=1u l=1u
X126 VSS.t82 vin2 vout2 VSS.t81 sg13_lv_nmos ad=0.19p pd=1.38u as=0.19p ps=1.38u w=1u l=1u
X127 vout1 vin1 VDD VDD sg13_lv_pmos ad=1.14p pd=6.38u as=1.14p ps=6.38u w=6u l=1u
X128 vout2 vin2 VSS.t85 VSS.t86 sg13_lv_nmos ad=0.19p pd=1.38u as=0.19p ps=1.38u w=1u l=1u
X129 VSS.t37 vin4 vout4 VSS.t136 sg13_lv_nmos ad=0.19p pd=1.38u as=0.19p ps=1.38u w=1u l=1u
X130 VSS.t58 VSS.t56 VSS.t30 VSS.t57 sg13_lv_nmos ad=0.19p pd=1.38u as=0 ps=0 w=1u l=1u
X131 VSS.t30 vin1 vout1 VSS.t29 sg13_lv_nmos ad=0.19p pd=1.38u as=0.19p ps=1.38u w=1u l=1u
X132 vout2 vin2 VSS.t49 VSS.t59 sg13_lv_nmos ad=0.19p pd=1.38u as=0.19p ps=1.38u w=1u l=1u
X133 VSS.t34 VSS.t31 VSS.t33 VSS.t32 sg13_lv_nmos ad=0.34p pd=2.68u as=0 ps=0 w=1u l=1u
X134 vout1 vin1 VSS.t3 VSS.t4 sg13_lv_nmos ad=0.19p pd=1.38u as=0.19p ps=1.38u w=1u l=1u
X135 VSS.t9 vin1 vout1 VSS.t8 sg13_lv_nmos ad=0.19p pd=1.38u as=0.19p ps=1.38u w=1u l=1u
X136 VDD vin3 vout3 VDD sg13_lv_pmos ad=1.14p pd=6.38u as=1.14p ps=6.38u w=6u l=1u
X137 VSS.t3 vin1 vout1 VSS.t2 sg13_lv_nmos ad=0.19p pd=1.38u as=0.19p ps=1.38u w=1u l=1u
X138 vout4 vin4 VDD VDD sg13_lv_pmos ad=1.14p pd=6.38u as=1.14p ps=6.38u w=6u l=1u
X139 vout3 vin3 VDD VDD sg13_lv_pmos ad=1.14p pd=6.38u as=1.14p ps=6.38u w=6u l=1u
X140 VDD vin3 vout3 VDD sg13_lv_pmos ad=1.14p pd=6.38u as=1.14p ps=6.38u w=6u l=1u
X141 VSS.t91 vin3 vout3 VSS.t63 sg13_lv_nmos ad=0.19p pd=1.38u as=0.19p ps=1.38u w=1u l=1u
X142 vout3 vin3 VSS.t93 VSS.t68 sg13_lv_nmos ad=0.19p pd=1.38u as=0.19p ps=1.38u w=1u l=1u
X143 vout1 vin1 VDD VDD sg13_lv_pmos ad=1.14p pd=6.38u as=1.14p ps=6.38u w=6u l=1u
X144 VSS.t85 vin2 vout2 VSS.t84 sg13_lv_nmos ad=0.19p pd=1.38u as=0.19p ps=1.38u w=1u l=1u
X145 VSS.t97 vin3 vout3 VSS.t72 sg13_lv_nmos ad=0.19p pd=1.38u as=0.19p ps=1.38u w=1u l=1u
X146 VDD vin4 vout4 VDD sg13_lv_pmos ad=1.14p pd=6.38u as=1.14p ps=6.38u w=6u l=1u
X147 vout1 vin1 VDD VDD sg13_lv_pmos ad=1.14p pd=6.38u as=1.14p ps=6.38u w=6u l=1u
X148 VDD vin1 vout1 VDD sg13_lv_pmos ad=1.14p pd=6.38u as=1.14p ps=6.38u w=6u l=1u
X149 vout4 vin4 VDD VDD sg13_lv_pmos ad=1.14p pd=6.38u as=1.14p ps=6.38u w=6u l=1u
X150 VSS.t24 vin1 vout1 VSS.t23 sg13_lv_nmos ad=0.19p pd=1.38u as=0.19p ps=1.38u w=1u l=1u
X151 vout1 vin1 VSS.t27 VSS.t28 sg13_lv_nmos ad=0.19p pd=1.38u as=0.19p ps=1.38u w=1u l=1u
X152 vout1 vin1 VDD VDD sg13_lv_pmos ad=1.14p pd=6.38u as=1.14p ps=6.38u w=6u l=1u
X153 vout2 vin2 VDD VDD sg13_lv_pmos ad=1.14p pd=6.38u as=1.14p ps=6.38u w=6u l=1u
X154 vout4 vin4 VSS.t113 VSS.t114 sg13_lv_nmos ad=0.19p pd=1.38u as=0.19p ps=1.38u w=1u l=1u
X155 VSS.t49 VSS.t47 VSS.t48 VSS.t40 sg13_lv_nmos ad=0.34p pd=2.68u as=0 ps=0 w=1u l=1u
X156 VSS.t46 VSS.t43 VSS.t45 VSS.t44 sg13_lv_nmos ad=0.19p pd=1.38u as=0 ps=0 w=1u l=1u
X157 vout4 vin4 VDD VDD sg13_lv_pmos ad=1.14p pd=6.38u as=1.14p ps=6.38u w=6u l=1u
X158 VSS.t45 vin3 vout3 VSS.t87 sg13_lv_nmos ad=0.19p pd=1.38u as=0.19p ps=1.38u w=1u l=1u
X159 VSS.t134 vin4 vout4 VSS.t133 sg13_lv_nmos ad=0.19p pd=1.38u as=0.19p ps=1.38u w=1u l=1u
X160 VDD vin4 vout4 VDD sg13_lv_pmos ad=1.14p pd=6.38u as=1.14p ps=6.38u w=6u l=1u
X161 vout1 vin1 VSS.t1 VSS.t0 sg13_lv_nmos ad=0.19p pd=1.38u as=0.19p ps=1.38u w=1u l=1u
X162 vout3 vin3 VSS.t89 VSS.t62 sg13_lv_nmos ad=0.19p pd=1.38u as=0.19p ps=1.38u w=1u l=1u
X163 VSS.t93 vin3 vout3 VSS.t66 sg13_lv_nmos ad=0.19p pd=1.38u as=0.19p ps=1.38u w=1u l=1u
X164 vout4 vin4 VDD VDD sg13_lv_pmos ad=1.14p pd=6.38u as=1.14p ps=6.38u w=6u l=1u
X165 vout2 vin2 VSS.t82 VSS.t83 sg13_lv_nmos ad=0.19p pd=1.38u as=0.19p ps=1.38u w=1u l=1u
X166 VSS.t89 vin3 vout3 VSS.t60 sg13_lv_nmos ad=0.19p pd=1.38u as=0.19p ps=1.38u w=1u l=1u
X167 VDD vin1 vout1 VDD sg13_lv_pmos ad=1.14p pd=6.38u as=1.14p ps=6.38u w=6u l=1u
X168 vout1 vin1 VDD VDD sg13_lv_pmos ad=1.14p pd=6.38u as=1.14p ps=6.38u w=6u l=1u
X169 VDD vin1 vout1 VDD sg13_lv_pmos ad=1.14p pd=6.38u as=1.14p ps=6.38u w=6u l=1u
X170 VDD vin4 vout4 VDD sg13_lv_pmos ad=1.14p pd=6.38u as=1.14p ps=6.38u w=6u l=1u
X171 VSS.t27 vin1 vout1 VSS.t26 sg13_lv_nmos ad=0.19p pd=1.38u as=0.19p ps=1.38u w=1u l=1u
X172 VDD vin2 vout2 VDD sg13_lv_pmos ad=1.14p pd=6.38u as=1.14p ps=6.38u w=6u l=1u
X173 vout2 vin2 VDD VDD sg13_lv_pmos ad=1.14p pd=6.38u as=1.14p ps=6.38u w=6u l=1u
X174 VDD vin2 vout2 VDD sg13_lv_pmos ad=1.14p pd=6.38u as=1.14p ps=6.38u w=6u l=1u
X175 VSS.t103 vin3 vout3 VSS.t81 sg13_lv_nmos ad=0.19p pd=1.38u as=0.19p ps=1.38u w=1u l=1u
R0 VSS.n46 VSS.n108 6777.49
R1 VSS.n8 VSS.n108 6777.49
R2 VSS.n440 VSS.n439 1580.41
R3 VSS.n344 VSS.n108 1580.41
R4 VSS.n69 VSS.n70 13.9766
R5 VSS.t59 VSS.n87 88.7251
R6 VSS.n331 VSS.t87 88.7251
R7 VSS.t60 VSS.n86 83.1798
R8 VSS.t86 VSS.n106 83.1798
R9 VSS.t62 VSS.n85 77.6345
R10 VSS.n105 VSS.t84 77.6345
R11 VSS.t32 VSS.n48 6.87896
R12 VSS.n45 VSS.t136 11.4002
R13 VSS.t63 VSS.n84 72.0892
R14 VSS.n104 VSS.t83 72.0892
R15 VSS.t136 VSS.n44 68.3206
R16 VSS.n47 VSS.t108 9.77299
R17 VSS.t65 VSS.n83 66.5439
R18 VSS.n103 VSS.t81 66.5439
R19 VSS.t135 VSS.n43 64.5255
R20 VSS.n27 VSS.t109 64.5209
R21 VSS.t66 VSS.n82 60.9987
R22 VSS.n102 VSS.t80 60.9987
R23 VSS.t133 VSS.n42 60.7305
R24 VSS.n28 VSS.t111 60.7259
R25 VSS.t132 VSS.n41 56.9354
R26 VSS.n29 VSS.t112 56.9308
R27 VSS.t28 VSS.n16 64.5222
R28 VSS.t68 VSS.n81 55.4534
R29 VSS.t72 VSS.n98 55.4534
R30 VSS.t74 VSS.n78 55.4534
R31 VSS.n101 VSS.t78 55.4534
R32 VSS.t130 VSS.n40 53.1403
R33 VSS.n30 VSS.t114 53.1357
R34 VSS.t69 VSS.n80 49.9081
R35 VSS.n97 VSS.t71 49.9081
R36 VSS.t75 VSS.n77 49.9081
R37 VSS.n100 VSS.t77 49.9081
R38 VSS.t129 VSS.n39 49.3453
R39 VSS.n31 VSS.t115 49.3407
R40 VSS.t25 VSS.n9 56.932
R41 VSS.t127 VSS.n38 45.5502
R42 VSS.t121 VSS.n34 45.5502
R43 VSS.n36 VSS.t123 45.5456
R44 VSS.n32 VSS.t117 45.5456
R45 VSS.n96 VSS.t69 44.3628
R46 VSS.t71 VSS.n79 44.3628
R47 VSS.n99 VSS.t75 44.3628
R48 VSS.t77 VSS.n76 44.3628
R49 VSS.t126 VSS.n37 41.7551
R50 VSS.t120 VSS.n33 41.7551
R51 VSS.n37 VSS.t124 41.7505
R52 VSS.n33 VSS.t118 41.7505
R53 VSS.t22 VSS.n18 49.3419
R54 VSS.n95 VSS.t68 38.8175
R55 VSS.n201 VSS.t72 38.8175
R56 VSS.n291 VSS.t74 38.8175
R57 VSS.t78 VSS.n75 38.8175
R58 VSS.t124 VSS.n36 37.9601
R59 VSS.t118 VSS.n32 37.9601
R60 VSS.n38 VSS.t126 37.9555
R61 VSS.n34 VSS.t120 37.9555
R62 VSS.t14 VSS.n5 45.5468
R63 VSS.t20 VSS.n7 45.5468
R64 VSS.t123 VSS.n35 34.1682
R65 VSS.t117 VSS.n31 34.165
R66 VSS.n35 VSS.t121 34.1635
R67 VSS.n39 VSS.t127 34.1604
R68 VSS.t13 VSS.n20 41.7518
R69 VSS.n94 VSS.t66 33.2722
R70 VSS.t80 VSS.n74 33.2722
R71 VSS.t115 VSS.n30 30.3699
R72 VSS.n40 VSS.t129 30.3653
R73 VSS.t11 VSS.n13 37.9567
R74 VSS.n93 VSS.t65 27.7269
R75 VSS.t81 VSS.n73 27.7269
R76 VSS.t114 VSS.n29 26.5749
R77 VSS.n41 VSS.t130 26.5703
R78 VSS.t10 VSS.n10 34.1624
R79 VSS.t16 VSS.n17 34.1648
R80 VSS.t112 VSS.n28 22.7798
R81 VSS.n42 VSS.t132 22.7752
R82 VSS.t8 VSS.n22 30.3666
R83 VSS.t26 VSS.n24 60.7281
R84 VSS.t17 VSS.n25 37.9577
R85 VSS.n8 VSS.t57 13.761
R86 VSS.n10 VSS.t8 49.3413
R87 VSS.n92 VSS.t63 22.1816
R88 VSS.t83 VSS.n72 22.1816
R89 VSS.t111 VSS.n27 18.9847
R90 VSS.n43 VSS.t133 18.9801
R91 VSS.t7 VSS.n19 26.5715
R92 VSS.t29 VSS.n4 11.3996
R93 VSS.n15 VSS.n2 0.0109013
R94 VSS.t26 VSS.n16 18.9817
R95 VSS.n3 VSS.n2 0.0109013
R96 VSS.n18 VSS.n2 0.0108886
R97 VSS.t19 VSS.n7 37.957
R98 VSS.n14 VSS.n2 0.0109013
R99 VSS.n25 VSS.n2 0.0108886
R100 VSS.n17 VSS.n2 0.0093246
R101 VSS.t14 VSS.n17 34.1651
R102 VSS.n20 VSS.n2 0.0109013
R103 VSS.t11 VSS.n20 41.7521
R104 VSS.t10 VSS.n13 45.5472
R105 VSS.n10 VSS.n2 0.0111485
R106 VSS.t7 VSS.n22 53.1373
R107 VSS.t5 VSS.n19 56.9324
R108 VSS.n12 VSS.n2 0.0109013
R109 VSS.t4 VSS.n12 60.7274
R110 VSS.t2 VSS.n21 64.5229
R111 VSS.n11 VSS.n2 0.0109013
R112 VSS.t0 VSS.n11 68.3176
R113 VSS.t56 VSS.n66 0.008067
R114 VSS.n2 VSS.n66 8.49747
R115 VSS.n2 VSS.n120 17.0005
R116 VSS.n121 VSS.n2 17.0005
R117 VSS.t58 VSS.n122 17.0005
R118 VSS.n128 VSS.t58 17.0005
R119 VSS.n127 VSS.t30 17.0005
R120 VSS.n128 VSS.t30 17.0005
R121 VSS.t58 VSS.n127 17.0005
R122 VSS.n122 VSS.t30 17.0005
R123 VSS.n23 VSS.n2 0.00291261
R124 VSS.n2 VSS.n26 0.010462
R125 VSS.n129 VSS.n2 17.0005
R126 VSS.n2 VSS.n132 17.0005
R127 VSS.n2 VSS.n111 17.0005
R128 VSS.t1 VSS.n130 17.0005
R129 VSS.n131 VSS.t1 17.0005
R130 VSS.t1 VSS.n119 17.0005
R131 VSS.n131 VSS.t55 17.0005
R132 VSS.t55 VSS.n119 17.0005
R133 VSS.n130 VSS.t55 17.0005
R134 VSS.n107 VSS.n70 17.0005
R135 VSS.n107 VSS.n343 17.0005
R136 VSS.n107 VSS.n162 17.0005
R137 VSS.n107 VSS.n341 17.0005
R138 VSS.n107 VSS.t44 17.0005
R139 VSS.n107 VSS.n337 17.0005
R140 VSS.n107 VSS.n335 17.0005
R141 VSS.n107 VSS.n164 17.0005
R142 VSS.n107 VSS.n333 17.0005
R143 VSS.n107 VSS.n166 17.0005
R144 VSS.n107 VSS.n331 17.0005
R145 VSS.n107 VSS.n169 17.0005
R146 VSS.n107 VSS.n330 17.0005
R147 VSS.n107 VSS.n172 17.0005
R148 VSS.n107 VSS.n106 17.0005
R149 VSS.n107 VSS.n176 17.0005
R150 VSS.n107 VSS.n65 17.0005
R151 VSS.n107 VSS.n328 17.0005
R152 VSS.n107 VSS.n71 17.0005
R153 VSS.n107 VSS.n105 17.0005
R154 VSS.n107 VSS.n324 17.0005
R155 VSS.n107 VSS.n178 17.0005
R156 VSS.n107 VSS.n322 17.0005
R157 VSS.n107 VSS.n72 17.0005
R158 VSS.n107 VSS.n104 17.0005
R159 VSS.n107 VSS.n183 17.0005
R160 VSS.n107 VSS.n54 8.49909
R161 VSS.n107 VSS.n320 17.0005
R162 VSS.n107 VSS.n73 17.0005
R163 VSS.n107 VSS.n103 17.0005
R164 VSS.n107 VSS.n186 17.0005
R165 VSS.n107 VSS.n188 17.0005
R166 VSS.n107 VSS.n318 17.0005
R167 VSS.n107 VSS.n74 17.0005
R168 VSS.n107 VSS.n102 17.0005
R169 VSS.n107 VSS.n190 17.0005
R170 VSS.n107 VSS.n312 17.0005
R171 VSS.n107 VSS.n310 17.0005
R172 VSS.n107 VSS.n75 17.0005
R173 VSS.n107 VSS.n101 17.0005
R174 VSS.n107 VSS.n193 17.0005
R175 VSS.n107 VSS.n195 17.0005
R176 VSS.n107 VSS.n308 17.0005
R177 VSS.n107 VSS.n76 17.0005
R178 VSS.n107 VSS.n100 17.0005
R179 VSS.n107 VSS.n197 17.0005
R180 VSS.n107 VSS.n302 17.0005
R181 VSS.n107 VSS.n300 17.0005
R182 VSS.n107 VSS.n77 17.0005
R183 VSS.n107 VSS.n198 17.0005
R184 VSS.n107 VSS.n99 17.0005
R185 VSS.n107 VSS.n200 17.0005
R186 VSS.n107 VSS.n295 17.0005
R187 VSS.n107 VSS.n78 17.0005
R188 VSS.n107 VSS.n291 17.0005
R189 VSS.n107 VSS.n0 17.0005
R190 VSS.n107 VSS.n289 17.0005
R191 VSS.n107 VSS.n58 17.0005
R192 VSS.n107 VSS.n201 17.0005
R193 VSS.n107 VSS.n98 17.0005
R194 VSS.n107 VSS.n204 17.0005
R195 VSS.n107 VSS.n206 17.0005
R196 VSS.n107 VSS.n287 17.0005
R197 VSS.n107 VSS.n79 17.0005
R198 VSS.n107 VSS.n97 17.0005
R199 VSS.n107 VSS.n208 17.0005
R200 VSS.n107 VSS.n281 17.0005
R201 VSS.n107 VSS.n279 17.0005
R202 VSS.n107 VSS.n80 17.0005
R203 VSS.n107 VSS.n96 17.0005
R204 VSS.n107 VSS.n211 17.0005
R205 VSS.n107 VSS.n277 17.0005
R206 VSS.n107 VSS.n81 17.0005
R207 VSS.n107 VSS.n95 17.0005
R208 VSS.n107 VSS.n217 17.0005
R209 VSS.n107 VSS.n219 17.0005
R210 VSS.n107 VSS.n275 17.0005
R211 VSS.n107 VSS.n82 17.0005
R212 VSS.n107 VSS.n94 17.0005
R213 VSS.n107 VSS.n271 17.0005
R214 VSS.n107 VSS.n221 17.0005
R215 VSS.n107 VSS.n269 17.0005
R216 VSS.n107 VSS.n83 17.0005
R217 VSS.n107 VSS.n93 17.0005
R218 VSS.n107 VSS.n226 17.0005
R219 VSS.n107 VSS.n267 17.0005
R220 VSS.n107 VSS.n50 8.49909
R221 VSS.n107 VSS.n84 17.0005
R222 VSS.n107 VSS.n92 17.0005
R223 VSS.n107 VSS.n229 17.0005
R224 VSS.n107 VSS.n265 17.0005
R225 VSS.n107 VSS.n85 17.0005
R226 VSS.n107 VSS.n91 17.0005
R227 VSS.n107 VSS.n235 17.0005
R228 VSS.n107 VSS.n263 17.0005
R229 VSS.n107 VSS.n60 8.49879
R230 VSS.n107 VSS.n86 17.0005
R231 VSS.n107 VSS.n236 17.0005
R232 VSS.n107 VSS.n90 17.0005
R233 VSS.n107 VSS.n238 17.0005
R234 VSS.n107 VSS.n258 17.0005
R235 VSS.n107 VSS.n256 17.0005
R236 VSS.n107 VSS.n87 17.0005
R237 VSS.n107 VSS.n89 17.0005
R238 VSS.n107 VSS.n241 17.0005
R239 VSS.n107 VSS.n254 17.0005
R240 VSS.n107 VSS.n244 17.0005
R241 VSS.n107 VSS.t40 17.0005
R242 VSS.n107 VSS.n247 17.0005
R243 VSS.n107 VSS.n249 17.0005
R244 VSS.n107 VSS.n250 4.25062
R245 VSS.n107 VSS.n434 17.0005
R246 VSS.n67 VSS.n69 0.505131
R247 VSS.n67 VSS.n106 17.0005
R248 VSS.n67 VSS.n71 17.0005
R249 VSS.n67 VSS.n105 17.0005
R250 VSS.n67 VSS.n72 17.0005
R251 VSS.n67 VSS.n104 17.0005
R252 VSS.n67 VSS.n73 17.0005
R253 VSS.n67 VSS.n103 17.0005
R254 VSS.n67 VSS.n74 17.0005
R255 VSS.n67 VSS.n102 17.0005
R256 VSS.n67 VSS.n75 17.0005
R257 VSS.n67 VSS.n101 17.0005
R258 VSS.n67 VSS.n76 17.0005
R259 VSS.n67 VSS.n100 17.0005
R260 VSS.n67 VSS.n77 17.0005
R261 VSS.n67 VSS.n99 17.0005
R262 VSS.n67 VSS.n78 17.0005
R263 VSS.n67 VSS.n98 17.0005
R264 VSS.n67 VSS.n79 17.0005
R265 VSS.n67 VSS.n97 17.0005
R266 VSS.n67 VSS.n80 17.0005
R267 VSS.n67 VSS.n96 17.0005
R268 VSS.n67 VSS.n81 17.0005
R269 VSS.n67 VSS.n95 17.0005
R270 VSS.n67 VSS.n82 17.0005
R271 VSS.n67 VSS.n94 17.0005
R272 VSS.n67 VSS.n83 17.0005
R273 VSS.n67 VSS.n93 17.0005
R274 VSS.n67 VSS.n84 17.0005
R275 VSS.n67 VSS.n92 17.0005
R276 VSS.n67 VSS.n85 17.0005
R277 VSS.n67 VSS.n91 17.0005
R278 VSS.n67 VSS.n86 17.0005
R279 VSS.n67 VSS.n90 17.0005
R280 VSS.n67 VSS.n87 17.0005
R281 VSS.n67 VSS.n89 17.0005
R282 VSS.n67 VSS.n436 17.0005
R283 VSS.n67 VSS.n438 17.0005
R284 VSS.n345 VSS.n1 17.0005
R285 VSS.n334 VSS.n1 17.0005
R286 VSS.n63 VSS.n1 17.0005
R287 VSS.n323 VSS.n1 17.0005
R288 VSS.n315 VSS.n1 17.0005
R289 VSS.n348 VSS.n1 17.0005
R290 VSS.n305 VSS.n1 17.0005
R291 VSS.n350 VSS.n1 17.0005
R292 VSS.n297 VSS.n1 17.0005
R293 VSS.n57 VSS.n1 17.0005
R294 VSS.n284 VSS.n1 17.0005
R295 VSS.n399 VSS.n1 17.0005
R296 VSS.n401 VSS.n1 17.0005
R297 VSS.n270 VSS.n1 17.0005
R298 VSS.n260 VSS.n1 17.0005
R299 VSS.n255 VSS.n1 17.0005
R300 VSS.n357 VSS.n46 17.0005
R301 VSS.n361 VSS.n46 17.0005
R302 VSS.n362 VSS.n46 17.0005
R303 VSS.n363 VSS.n46 17.0005
R304 VSS.n365 VSS.n46 17.0005
R305 VSS.n377 VSS.n46 17.0005
R306 VSS.n380 VSS.t38 17.0005
R307 VSS.t38 VSS.n364 17.0005
R308 VSS.t38 VSS.n379 17.0005
R309 VSS.n379 VSS.t37 17.0005
R310 VSS.n364 VSS.t37 17.0005
R311 VSS.n380 VSS.t37 17.0005
R312 VSS.n383 VSS.t34 17.0005
R313 VSS.n382 VSS.t34 17.0005
R314 VSS.n384 VSS.t34 17.0005
R315 VSS.t33 VSS.n382 17.0005
R316 VSS.n384 VSS.t33 17.0005
R317 VSS.t33 VSS.n383 17.0005
R318 VSS.n91 VSS.t62 16.6364
R319 VSS.t84 VSS.n71 16.6364
R320 VSS.t109 VSS.n47 15.1993
R321 VSS.n44 VSS.t135 15.1851
R322 VSS.t5 VSS.n12 22.7764
R323 VSS.t47 VSS.n406 15.0005
R324 VSS.n415 VSS.t39 15.0005
R325 VSS.n430 VSS.t43 15.0005
R326 VSS.t50 VSS.n408 15.0005
R327 VSS.n435 VSS.n161 12.4949
R328 VSS.n438 VSS.n88 12.4949
R329 VSS.n162 VSS.n133 12.4949
R330 VSS.n341 VSS.n134 12.4949
R331 VSS.n164 VSS.n135 12.4949
R332 VSS.n166 VSS.n136 12.4949
R333 VSS.n169 VSS.n137 12.4949
R334 VSS.n172 VSS.n138 12.4949
R335 VSS.n176 VSS.n139 12.4949
R336 VSS.n178 VSS.n140 12.4949
R337 VSS.n183 VSS.n141 12.4949
R338 VSS.n186 VSS.n142 12.4949
R339 VSS.n190 VSS.n143 12.4949
R340 VSS.n193 VSS.n144 12.4949
R341 VSS.n197 VSS.n145 12.4949
R342 VSS.n200 VSS.n146 12.4949
R343 VSS.n0 VSS.n147 12.4949
R344 VSS.n201 VSS.n148 12.4949
R345 VSS.n204 VSS.n149 12.4949
R346 VSS.n208 VSS.n150 12.4949
R347 VSS.n211 VSS.n151 12.4949
R348 VSS.n217 VSS.n152 12.4949
R349 VSS.n221 VSS.n153 12.4949
R350 VSS.n226 VSS.n154 12.4949
R351 VSS.n229 VSS.n155 12.4949
R352 VSS.n235 VSS.n156 12.4949
R353 VSS.n238 VSS.n157 12.4949
R354 VSS.n241 VSS.n158 12.4949
R355 VSS.n244 VSS.n159 12.4949
R356 VSS.n247 VSS.n160 12.4949
R357 VSS.n439 VSS.n88 12.4949
R358 VSS.n436 VSS.n435 12.4949
R359 VSS.n161 VSS.n160 12.4949
R360 VSS.t40 VSS.n159 12.4949
R361 VSS.n254 VSS.n158 12.4949
R362 VSS.n258 VSS.n157 12.4949
R363 VSS.n263 VSS.n156 12.4949
R364 VSS.n265 VSS.n155 12.4949
R365 VSS.n267 VSS.n154 12.4949
R366 VSS.n269 VSS.n153 12.4949
R367 VSS.n275 VSS.n152 12.4949
R368 VSS.n277 VSS.n151 12.4949
R369 VSS.n281 VSS.n150 12.4949
R370 VSS.n287 VSS.n149 12.4949
R371 VSS.n289 VSS.n148 12.4949
R372 VSS.n291 VSS.n147 12.4949
R373 VSS.n295 VSS.n146 12.4949
R374 VSS.n302 VSS.n145 12.4949
R375 VSS.n308 VSS.n144 12.4949
R376 VSS.n312 VSS.n143 12.4949
R377 VSS.n318 VSS.n142 12.4949
R378 VSS.n320 VSS.n141 12.4949
R379 VSS.n322 VSS.n140 12.4949
R380 VSS.n328 VSS.n139 12.4949
R381 VSS.n330 VSS.n138 12.4949
R382 VSS.n331 VSS.n137 12.4949
R383 VSS.n333 VSS.n136 12.4949
R384 VSS.n337 VSS.n135 12.4949
R385 VSS.t44 VSS.n134 12.4949
R386 VSS.n343 VSS.n133 12.4949
R387 VSS.n47 VSS.n46 0.00253296
R388 VSS.t4 VSS.n21 18.9808
R389 VSS.t54 VSS.n6 13.76
R390 VSS.n5 VSS.t13 37.9577
R391 VSS.n25 VSS.t16 45.5468
R392 VSS.n14 VSS.t17 41.7518
R393 VSS.n18 VSS.t20 34.1626
R394 VSS.n3 VSS.t22 30.3666
R395 VSS.n9 VSS.t23 26.5725
R396 VSS.n24 VSS.t25 22.7764
R397 VSS.n15 VSS.t28 15.1863
R398 VSS.t57 VSS.n4 13.7582
R399 VSS.n90 VSS.t60 11.0911
R400 VSS.n172 VSS.t86 11.0911
R401 VSS.n440 VSS.n6 6777.49
R402 VSS.n112 VSS.n344 3.40102
R403 VSS.n344 VSS.n69 2.79655
R404 VSS.n68 VSS.n67 0.00356698
R405 VSS.n166 VSS.n1 8.5005
R406 VSS.n331 VSS.n1 8.5005
R407 VSS.n172 VSS.n1 8.5005
R408 VSS.n291 VSS.n1 8.5005
R409 VSS.n201 VSS.n1 8.5005
R410 VSS.n161 VSS.n1 8.5005
R411 VSS.n107 VSS.n339 8.4984
R412 VSS.n107 VSS.n165 8.4984
R413 VSS.n107 VSS.n168 8.4984
R414 VSS.n107 VSS.n171 8.4984
R415 VSS.n107 VSS.n174 8.4984
R416 VSS.n107 VSS.n326 8.4984
R417 VSS.n107 VSS.n179 8.4984
R418 VSS.n107 VSS.n181 8.4984
R419 VSS.n107 VSS.n184 8.4984
R420 VSS.n107 VSS.n316 8.4984
R421 VSS.n107 VSS.n313 8.4984
R422 VSS.n107 VSS.n191 8.4984
R423 VSS.n107 VSS.n306 8.4984
R424 VSS.n107 VSS.n303 8.4984
R425 VSS.n107 VSS.n298 8.4984
R426 VSS.n107 VSS.n293 8.4984
R427 VSS.n107 VSS.n290 8.4984
R428 VSS.n107 VSS.n202 8.4984
R429 VSS.n107 VSS.n285 8.4984
R430 VSS.n107 VSS.n282 8.4984
R431 VSS.n107 VSS.n209 8.4984
R432 VSS.n107 VSS.n213 8.4984
R433 VSS.n107 VSS.n215 8.4984
R434 VSS.n107 VSS.n273 8.4984
R435 VSS.n107 VSS.n222 8.4984
R436 VSS.n107 VSS.n224 8.4984
R437 VSS.n107 VSS.n227 8.4984
R438 VSS.n107 VSS.n231 8.4984
R439 VSS.n107 VSS.n233 8.4984
R440 VSS.n107 VSS.n261 8.4984
R441 VSS.n107 VSS.n239 8.4984
R442 VSS.n107 VSS.n243 8.4984
R443 VSS.n107 VSS.n246 8.4984
R444 VSS.n338 VSS.n1 8.4984
R445 VSS.n167 VSS.n1 8.4984
R446 VSS.n170 VSS.n1 8.4984
R447 VSS.n173 VSS.n1 8.4984
R448 VSS.n64 VSS.n1 8.4984
R449 VSS.n325 VSS.n1 8.4984
R450 VSS.n180 VSS.n1 8.4984
R451 VSS.n55 VSS.n1 8.4984
R452 VSS.n53 VSS.n1 8.4984
R453 VSS.n187 VSS.n1 8.4984
R454 VSS.n314 VSS.n1 8.4984
R455 VSS.n309 VSS.n1 8.4984
R456 VSS.n194 VSS.n1 8.4984
R457 VSS.n304 VSS.n1 8.4984
R458 VSS.n299 VSS.n1 8.4984
R459 VSS.n296 VSS.n1 8.4984
R460 VSS.n292 VSS.n1 8.4984
R461 VSS.n288 VSS.n1 8.4984
R462 VSS.n205 VSS.n1 8.4984
R463 VSS.n283 VSS.n1 8.4984
R464 VSS.n278 VSS.n1 8.4984
R465 VSS.n212 VSS.n1 8.4984
R466 VSS.n214 VSS.n1 8.4984
R467 VSS.n218 VSS.n1 8.4984
R468 VSS.n272 VSS.n1 8.4984
R469 VSS.n223 VSS.n1 8.4984
R470 VSS.n49 VSS.n1 8.4984
R471 VSS.n51 VSS.n1 8.4984
R472 VSS.n230 VSS.n1 8.4984
R473 VSS.n232 VSS.n1 8.4984
R474 VSS.n59 VSS.n1 8.4984
R475 VSS.n61 VSS.n1 8.4984
R476 VSS.n259 VSS.n1 8.4984
R477 VSS.n242 VSS.n1 8.4984
R478 VSS.n245 VSS.n1 8.4984
R479 VSS.n248 VSS.n1 8.4984
R480 VSS.n45 VSS.t36 6.87897
R481 VSS.n46 VSS.n48 0.00129054
R482 VSS.t2 VSS.n11 15.1863
R483 VSS.n412 VSS.t47 7.49606
R484 VSS.t39 VSS.n405 7.49606
R485 VSS.t43 VSS.n429 7.49606
R486 VSS.n409 VSS.t50 7.49606
R487 VSS.n1 VSS.n0 7.41821
R488 VSS.n289 VSS.n1 7.41821
R489 VSS.n342 VSS.n70 7.20236
R490 VSS.n341 VSS.n340 7.20236
R491 VSS.n336 VSS.t44 7.20236
R492 VSS.n332 VSS.n164 7.20236
R493 VSS.n329 VSS.n169 7.20236
R494 VSS.n175 VSS.n106 7.20236
R495 VSS.n328 VSS.n327 7.20236
R496 VSS.n178 VSS.n177 7.20236
R497 VSS.n322 VSS.n321 7.20236
R498 VSS.n183 VSS.n182 7.20236
R499 VSS.n320 VSS.n319 7.20236
R500 VSS.n186 VSS.n185 7.20236
R501 VSS.n317 VSS.n74 7.20236
R502 VSS.n189 VSS.n102 7.20236
R503 VSS.n311 VSS.n75 7.20236
R504 VSS.n192 VSS.n101 7.20236
R505 VSS.n307 VSS.n76 7.20236
R506 VSS.n197 VSS.n196 7.20236
R507 VSS.n301 VSS.n77 7.20236
R508 VSS.n200 VSS.n199 7.20236
R509 VSS.n294 VSS.n78 7.20236
R510 VSS.n203 VSS.n98 7.20236
R511 VSS.n287 VSS.n286 7.20236
R512 VSS.n207 VSS.n97 7.20236
R513 VSS.n281 VSS.n280 7.20236
R514 VSS.n210 VSS.n96 7.20236
R515 VSS.n276 VSS.n81 7.20236
R516 VSS.n217 VSS.n216 7.20236
R517 VSS.n274 VSS.n82 7.20236
R518 VSS.n221 VSS.n220 7.20236
R519 VSS.n269 VSS.n268 7.20236
R520 VSS.n225 VSS.n93 7.20236
R521 VSS.n266 VSS.n84 7.20236
R522 VSS.n228 VSS.n92 7.20236
R523 VSS.n264 VSS.n85 7.20236
R524 VSS.n234 VSS.n91 7.20236
R525 VSS.n263 VSS.n262 7.20236
R526 VSS.n238 VSS.n237 7.20236
R527 VSS.n257 VSS.n87 7.20236
R528 VSS.n241 VSS.n240 7.20236
R529 VSS.n254 VSS.n253 7.20236
R530 VSS.t40 VSS.n252 7.20236
R531 VSS.n437 VSS.n436 7.20236
R532 VSS.n438 VSS.n437 7.20236
R533 VSS.n252 VSS.n247 7.20236
R534 VSS.n253 VSS.n244 7.20236
R535 VSS.n240 VSS.n89 7.20236
R536 VSS.n258 VSS.n257 7.20236
R537 VSS.n237 VSS.n90 7.20236
R538 VSS.n262 VSS.n86 7.20236
R539 VSS.n235 VSS.n234 7.20236
R540 VSS.n265 VSS.n264 7.20236
R541 VSS.n229 VSS.n228 7.20236
R542 VSS.n267 VSS.n266 7.20236
R543 VSS.n226 VSS.n225 7.20236
R544 VSS.n268 VSS.n83 7.20236
R545 VSS.n220 VSS.n94 7.20236
R546 VSS.n275 VSS.n274 7.20236
R547 VSS.n216 VSS.n95 7.20236
R548 VSS.n277 VSS.n276 7.20236
R549 VSS.n211 VSS.n210 7.20236
R550 VSS.n280 VSS.n80 7.20236
R551 VSS.n208 VSS.n207 7.20236
R552 VSS.n286 VSS.n79 7.20236
R553 VSS.n204 VSS.n203 7.20236
R554 VSS.n295 VSS.n294 7.20236
R555 VSS.n199 VSS.n99 7.20236
R556 VSS.n302 VSS.n301 7.20236
R557 VSS.n196 VSS.n100 7.20236
R558 VSS.n308 VSS.n307 7.20236
R559 VSS.n193 VSS.n192 7.20236
R560 VSS.n312 VSS.n311 7.20236
R561 VSS.n190 VSS.n189 7.20236
R562 VSS.n318 VSS.n317 7.20236
R563 VSS.n185 VSS.n103 7.20236
R564 VSS.n319 VSS.n73 7.20236
R565 VSS.n182 VSS.n104 7.20236
R566 VSS.n321 VSS.n72 7.20236
R567 VSS.n177 VSS.n105 7.20236
R568 VSS.n327 VSS.n71 7.20236
R569 VSS.n176 VSS.n175 7.20236
R570 VSS.n330 VSS.n329 7.20236
R571 VSS.n333 VSS.n332 7.20236
R572 VSS.n337 VSS.n336 7.20236
R573 VSS.n340 VSS.n162 7.20236
R574 VSS.n343 VSS.n342 7.20236
R575 VSS.n8 VSS.n2 0.00104987
R576 VSS.n439 VSS.n110 1.88975
R577 VSS.n107 VSS.n110 0.00338844
R578 VSS.n89 VSS.t59 5.54579
R579 VSS.t87 VSS.n166 5.54579
R580 VSS.n413 VSS.t49 4.5005
R581 VSS.t42 VSS.n404 4.5005
R582 VSS.n410 VSS.t51 4.5005
R583 VSS.n433 VSS.t45 4.5005
R584 VSS.n251 VSS.n1 4.25219
R585 VSS.n163 VSS.n1 4.25206
R586 VSS.n107 VSS.n163 4.25175
R587 VSS.n107 VSS.n251 4.25169
R588 VSS.t0 VSS.n23 11.3992
R589 VSS.n462 VSS.n114 3.77525
R590 VSS.n463 VSS.n462 3.77525
R591 VSS.n396 VSS.n395 3.77525
R592 VSS.n395 VSS.n353 3.77525
R593 VSS.n126 VSS.t56 3.0005
R594 VSS.n458 VSS.t53 3.0005
R595 VSS.n378 VSS.t35 3.0005
R596 VSS.t31 VSS.n385 3.0005
R597 VSS.n411 VSS.n403 3.0005
R598 VSS.n417 VSS.n416 3.0005
R599 VSS.n407 VSS.n347 3.0005
R600 VSS.n432 VSS.n431 3.0005
R601 VSS.t29 VSS.n15 68.3176
R602 VSS.t23 VSS.n3 53.1373
R603 VSS.t19 VSS.n14 41.7521
R604 VSS.n21 VSS.n2 0.0111485
R605 VSS.n4 VSS.n2 0.00289146
R606 VSS.n16 VSS.n2 0.0109013
R607 VSS.n24 VSS.n2 0.0108886
R608 VSS.n9 VSS.n2 0.0108886
R609 VSS.n7 VSS.n2 0.0109013
R610 VSS.n5 VSS.n2 0.0108886
R611 VSS.n13 VSS.n2 0.0109013
R612 VSS.n22 VSS.n2 0.0109013
R613 VSS.n19 VSS.n2 0.0109013
R614 VSS.t54 VSS.n23 13.7592
R615 VSS.n6 VSS.n2 0.0010491
R616 VSS.n459 VSS.t3 2.4821
R617 VSS.n460 VSS.t6 2.4821
R618 VSS.n461 VSS.t9 2.4821
R619 VSS.n118 VSS.t12 2.4821
R620 VSS.t18 VSS.n117 2.4821
R621 VSS.n123 VSS.t21 2.4821
R622 VSS.n124 VSS.t24 2.4821
R623 VSS.n125 VSS.t27 2.4821
R624 VSS.t134 VSS.n366 2.4821
R625 VSS.n367 VSS.t131 2.4821
R626 VSS.t128 VSS.n368 2.4821
R627 VSS.t125 VSS.n354 2.4821
R628 VSS.t119 VSS.n355 2.4821
R629 VSS.n358 VSS.t116 2.4821
R630 VSS.n359 VSS.t113 2.4821
R631 VSS.n360 VSS.t110 2.4821
R632 VSS.n419 VSS.t89 2.4821
R633 VSS.n419 VSS.t61 2.4821
R634 VSS.n420 VSS.t91 2.4821
R635 VSS.n420 VSS.t64 2.4821
R636 VSS.n421 VSS.t93 2.4821
R637 VSS.n421 VSS.t67 2.4821
R638 VSS.n422 VSS.t95 2.4821
R639 VSS.n422 VSS.t70 2.4821
R640 VSS.n424 VSS.t99 2.4821
R641 VSS.n424 VSS.t76 2.4821
R642 VSS.n425 VSS.t101 2.4821
R643 VSS.n425 VSS.t79 2.4821
R644 VSS.n426 VSS.t103 2.4821
R645 VSS.n426 VSS.t82 2.4821
R646 VSS.n427 VSS.t105 2.4821
R647 VSS.n427 VSS.t85 2.4821
R648 VSS.n353 VSS.n352 2.4377
R649 VSS.n435 VSS.n107 2.25406
R650 VSS.n107 VSS.n88 2.25406
R651 VSS.n67 VSS.n133 2.25406
R652 VSS.n67 VSS.n134 2.25406
R653 VSS.n67 VSS.n135 2.25406
R654 VSS.n67 VSS.n136 2.25406
R655 VSS.n67 VSS.n137 2.25406
R656 VSS.n67 VSS.n138 2.25406
R657 VSS.n67 VSS.n139 2.25406
R658 VSS.n67 VSS.n140 2.25406
R659 VSS.n67 VSS.n141 2.25406
R660 VSS.n67 VSS.n142 2.25406
R661 VSS.n67 VSS.n143 2.25406
R662 VSS.n67 VSS.n144 2.25406
R663 VSS.n67 VSS.n145 2.25406
R664 VSS.n67 VSS.n146 2.25406
R665 VSS.n67 VSS.n147 2.25406
R666 VSS.n67 VSS.n148 2.25406
R667 VSS.n67 VSS.n149 2.25406
R668 VSS.n67 VSS.n150 2.25406
R669 VSS.n67 VSS.n151 2.25406
R670 VSS.n67 VSS.n152 2.25406
R671 VSS.n67 VSS.n153 2.25406
R672 VSS.n67 VSS.n154 2.25406
R673 VSS.n67 VSS.n155 2.25406
R674 VSS.n67 VSS.n156 2.25406
R675 VSS.n67 VSS.n157 2.25406
R676 VSS.n67 VSS.n158 2.25406
R677 VSS.n67 VSS.n159 2.25406
R678 VSS.n67 VSS.n160 2.25406
R679 VSS.t48 VSS.n413 2.2505
R680 VSS.t41 VSS.n404 2.2505
R681 VSS.t52 VSS.n410 2.2505
R682 VSS.t46 VSS.n433 2.2505
R683 VSS.n443 VSS.n2 2.09947
R684 VSS.n445 VSS.n2 2.09947
R685 VSS.n447 VSS.n2 2.09947
R686 VSS.n115 VSS.n2 2.09947
R687 VSS.n449 VSS.n2 2.09947
R688 VSS.n451 VSS.n2 2.09947
R689 VSS.n453 VSS.n2 2.09947
R690 VSS.n455 VSS.n2 2.09947
R691 VSS.n372 VSS.n46 2.09888
R692 VSS.n390 VSS.n46 2.09885
R693 VSS.n394 VSS.n46 2.0988
R694 VSS.n388 VSS.n46 2.09868
R695 VSS.n374 VSS.n46 2.09868
R696 VSS.n392 VSS.n46 2.09862
R697 VSS.n370 VSS.n46 2.09862
R698 VSS.n46 VSS.n109 2.09849
R699 VSS.n398 VSS.n397 1.88787
R700 VSS.n398 VSS.n113 1.88787
R701 VSS.n344 VSS.n1 1.7005
R702 VSS.n439 VSS.n1 1.7005
R703 VSS.n434 VSS.n68 1.03817
R704 VSS.n26 VSS.n128 1.37924
R705 VSS.n458 VSS.n119 1.52811
R706 VSS.n379 VSS.n378 1.52811
R707 VSS.n385 VSS.n384 1.52811
R708 VSS.n127 VSS.n126 1.52811
R709 VSS.n382 VSS.n381 1.42159
R710 VSS.n381 VSS.n380 1.37894
R711 VSS.n463 VSS.n113 1.1929
R712 VSS.n353 VSS.n113 1.1929
R713 VSS.n397 VSS.n114 1.1929
R714 VSS.n397 VSS.n396 1.1929
R715 VSS.t48 VSS.n1 1.08341
R716 VSS.n1 VSS.t52 1.03696
R717 VSS.n441 VSS.n2 0.96569
R718 VSS.n457 VSS.n2 0.91152
R719 VSS.n386 VSS.n46 0.910334
R720 VSS.n376 VSS.n46 0.909148
R721 VSS.n340 VSS.n1 0.650322
R722 VSS.n336 VSS.n1 0.650322
R723 VSS.n332 VSS.n1 0.650322
R724 VSS.n329 VSS.n1 0.650322
R725 VSS.n175 VSS.n1 0.650322
R726 VSS.n327 VSS.n1 0.650322
R727 VSS.n177 VSS.n1 0.650322
R728 VSS.n321 VSS.n1 0.650322
R729 VSS.n182 VSS.n1 0.650322
R730 VSS.n319 VSS.n1 0.650322
R731 VSS.n185 VSS.n1 0.650322
R732 VSS.n317 VSS.n1 0.650322
R733 VSS.n189 VSS.n1 0.650322
R734 VSS.n311 VSS.n1 0.650322
R735 VSS.n192 VSS.n1 0.650322
R736 VSS.n307 VSS.n1 0.650322
R737 VSS.n196 VSS.n1 0.650322
R738 VSS.n301 VSS.n1 0.650322
R739 VSS.n199 VSS.n1 0.650322
R740 VSS.n294 VSS.n1 0.650322
R741 VSS.n203 VSS.n1 0.650322
R742 VSS.n286 VSS.n1 0.650322
R743 VSS.n207 VSS.n1 0.650322
R744 VSS.n280 VSS.n1 0.650322
R745 VSS.n210 VSS.n1 0.650322
R746 VSS.n276 VSS.n1 0.650322
R747 VSS.n216 VSS.n1 0.650322
R748 VSS.n274 VSS.n1 0.650322
R749 VSS.n220 VSS.n1 0.650322
R750 VSS.n268 VSS.n1 0.650322
R751 VSS.n225 VSS.n1 0.650322
R752 VSS.n266 VSS.n1 0.650322
R753 VSS.n228 VSS.n1 0.650322
R754 VSS.n264 VSS.n1 0.650322
R755 VSS.n234 VSS.n1 0.650322
R756 VSS.n262 VSS.n1 0.650322
R757 VSS.n237 VSS.n1 0.650322
R758 VSS.n257 VSS.n1 0.650322
R759 VSS.n240 VSS.n1 0.650322
R760 VSS.n253 VSS.n1 0.650322
R761 VSS.n252 VSS.n1 0.650322
R762 VSS.n437 VSS.n1 0.650322
R763 VSS VSS.n463 0.3585
R764 VSS.n114 VSS 0.3585
R765 VSS.n396 VSS.n352 0.3585
R766 VSS.n459 VSS.n458 0.209825
R767 VSS.n378 VSS.n366 0.209825
R768 VSS.n385 VSS.n360 0.209825
R769 VSS.n126 VSS.n125 0.209825
R770 VSS.n456 VSS.t3 0.201663
R771 VSS.n454 VSS.t6 0.201663
R772 VSS.n452 VSS.t9 0.201663
R773 VSS.n450 VSS.t12 0.201663
R774 VSS.n448 VSS.t18 0.201663
R775 VSS.n446 VSS.t21 0.201663
R776 VSS.n444 VSS.t24 0.201663
R777 VSS.n442 VSS.t27 0.201663
R778 VSS.n375 VSS.t134 0.201663
R779 VSS.n373 VSS.t131 0.201663
R780 VSS.n371 VSS.t128 0.201663
R781 VSS.n369 VSS.t125 0.201663
R782 VSS.n393 VSS.t119 0.201663
R783 VSS.n391 VSS.t116 0.201663
R784 VSS.n389 VSS.t113 0.201663
R785 VSS.n387 VSS.t110 0.201663
R786 VSS.n62 VSS.t89 0.201663
R787 VSS.t61 VSS.n62 0.201663
R788 VSS.n52 VSS.t91 0.201663
R789 VSS.t64 VSS.n52 0.201663
R790 VSS.n402 VSS.t93 0.201663
R791 VSS.t67 VSS.n402 0.201663
R792 VSS.n400 VSS.t95 0.201663
R793 VSS.t70 VSS.n400 0.201663
R794 VSS.n351 VSS.t99 0.201663
R795 VSS.t76 VSS.n351 0.201663
R796 VSS.n349 VSS.t101 0.201663
R797 VSS.t79 VSS.n349 0.201663
R798 VSS.n56 VSS.t103 0.201663
R799 VSS.t82 VSS.n56 0.201663
R800 VSS.n65 VSS.t105 0.201663
R801 VSS.t85 VSS.n65 0.201663
R802 VSS.n130 VSS.n26 1.42656
R803 VSS.t73 VSS.t97 0.185696
R804 VSS.n460 VSS.n459 0.16242
R805 VSS.n461 VSS.n460 0.16242
R806 VSS.n118 VSS.n461 0.16242
R807 VSS.n116 VSS.n118 0.16242
R808 VSS.n116 VSS.n117 0.16242
R809 VSS.n123 VSS.n117 0.16242
R810 VSS.n124 VSS.n123 0.16242
R811 VSS.n125 VSS.n124 0.16242
R812 VSS.n360 VSS.n359 0.16242
R813 VSS.n359 VSS.n358 0.16242
R814 VSS.n358 VSS.n355 0.16242
R815 VSS.n356 VSS.n355 0.16242
R816 VSS.n356 VSS.n354 0.16242
R817 VSS.n368 VSS.n354 0.16242
R818 VSS.n368 VSS.n367 0.16242
R819 VSS.n367 VSS.n366 0.16242
R820 VSS.n376 VSS.n375 0.147329
R821 VSS.n387 VSS.n386 0.145358
R822 VSS.n457 VSS.n456 0.144129
R823 VSS.n442 VSS.n441 0.143085
R824 VSS.n419 VSS.n418 0.117247
R825 VSS.n428 VSS.n427 0.1171
R826 VSS.n456 VSS.n455 0.0952183
R827 VSS.n388 VSS.n387 0.0942639
R828 VSS.n375 VSS.n374 0.0935007
R829 VSS.n454 VSS.n453 0.0927738
R830 VSS.n443 VSS.n442 0.0925656
R831 VSS.n390 VSS.n389 0.0918813
R832 VSS.n373 VSS.n372 0.0908079
R833 VSS.n452 VSS.n451 0.0903294
R834 VSS.t15 VSS.n115 0.0903294
R835 VSS.n445 VSS.n444 0.0901212
R836 VSS.n392 VSS.n391 0.08912
R837 VSS.n371 VSS.n370 0.08912
R838 VSS.t122 VSS.n109 0.0889841
R839 VSS.t122 VSS.n394 0.0884862
R840 VSS.n450 VSS.n449 0.0878849
R841 VSS.n448 VSS.n447 0.0878849
R842 VSS.n449 VSS.t15 0.0876767
R843 VSS.n447 VSS.n446 0.0876767
R844 VSS.n394 VSS.n393 0.0870574
R845 VSS.n369 VSS.n109 0.086547
R846 VSS.n393 VSS.n392 0.0864173
R847 VSS.n370 VSS.n369 0.0864173
R848 VSS.n446 VSS.n445 0.0854405
R849 VSS.n451 VSS.n450 0.0852323
R850 VSS.n115 VSS.n448 0.0852323
R851 VSS.n441 VSS.t56 0.0849321
R852 VSS.t53 VSS.n457 0.0847768
R853 VSS.n372 VSS.n371 0.084742
R854 VSS.n391 VSS.n390 0.0836579
R855 VSS.n386 VSS.t31 0.0834709
R856 VSS.n444 VSS.n443 0.082996
R857 VSS.n453 VSS.n452 0.0827878
R858 VSS.t35 VSS.n376 0.0824029
R859 VSS.n374 VSS.n373 0.0820417
R860 VSS.n420 VSS.n419 0.08146
R861 VSS.n421 VSS.n420 0.08146
R862 VSS.n422 VSS.n421 0.08146
R863 VSS.n423 VSS.n422 0.08146
R864 VSS.n424 VSS.n423 0.08146
R865 VSS.n425 VSS.n424 0.08146
R866 VSS.n426 VSS.n425 0.08146
R867 VSS.n427 VSS.n426 0.08146
R868 VSS.n389 VSS.n388 0.0812785
R869 VSS.n455 VSS.n454 0.0803434
R870 VSS.t41 VSS.n250 0.0592831
R871 VSS.n434 VSS.t46 0.0592831
R872 VSS.n250 VSS.n68 1.29808
R873 VSS.n352 VSS 0.0445
R874 VSS.n356 VSS.t122 0.0394179
R875 VSS.t15 VSS.n116 0.0394179
R876 VSS.n462 VSS.n116 0.0389615
R877 VSS.n395 VSS.n356 0.0389615
R878 VSS.t49 VSS.n412 0.031258
R879 VSS.n405 VSS.t42 0.031258
R880 VSS.t51 VSS.n409 0.031258
R881 VSS.n418 VSS.n417 0.0291125
R882 VSS.n428 VSS.n347 0.0291125
R883 VSS.n432 VSS.n428 0.0291125
R884 VSS.n418 VSS.n403 0.0291125
R885 VSS.n417 VSS.n404 0.0281144
R886 VSS.n410 VSS.n347 0.0281144
R887 VSS.n433 VSS.n432 0.0281144
R888 VSS.n413 VSS.n403 0.0281144
R889 VSS.n429 VSS.n346 0.0216549
R890 VSS.n430 VSS.t45 0.0208704
R891 VSS.n411 VSS.n406 0.0202884
R892 VSS.n416 VSS.n415 0.0202884
R893 VSS.n431 VSS.n430 0.0202884
R894 VSS.n408 VSS.n407 0.0202884
R895 VSS.n423 VSS.n398 0.0197308
R896 VSS.n423 VSS.t97 0.019449
R897 VSS.n346 VSS.n163 0.0162424
R898 VSS.n414 VSS.n251 0.0159649
R899 VSS.t53 VSS.n111 0.0133922
R900 VSS.t35 VSS.n377 0.0133922
R901 VSS.t31 VSS.n357 0.0133922
R902 VSS.n339 VSS.n338 0.0118857
R903 VSS.n167 VSS.n165 0.0118857
R904 VSS.n171 VSS.n170 0.0118857
R905 VSS.n173 VSS.n171 0.0118857
R906 VSS.n64 VSS.n174 0.0118857
R907 VSS.n326 VSS.n325 0.0118857
R908 VSS.n180 VSS.n179 0.0118857
R909 VSS.n55 VSS.n181 0.0118857
R910 VSS.n53 VSS.n184 0.0118857
R911 VSS.n187 VSS.n184 0.0118857
R912 VSS.n316 VSS.n314 0.0118857
R913 VSS.n309 VSS.n191 0.0118857
R914 VSS.n194 VSS.n191 0.0118857
R915 VSS.n306 VSS.n304 0.0118857
R916 VSS.n298 VSS.n296 0.0118857
R917 VSS.n293 VSS.n292 0.0118857
R918 VSS.n205 VSS.n202 0.0118857
R919 VSS.n285 VSS.n283 0.0118857
R920 VSS.n212 VSS.n209 0.0118857
R921 VSS.n214 VSS.n213 0.0118857
R922 VSS.n273 VSS.n272 0.0118857
R923 VSS.n223 VSS.n222 0.0118857
R924 VSS.n231 VSS.n230 0.0118857
R925 VSS.n233 VSS.n232 0.0118857
R926 VSS.n59 VSS.n233 0.0118857
R927 VSS.n261 VSS.n259 0.0118857
R928 VSS.n242 VSS.n239 0.0118857
R929 VSS.n245 VSS.n243 0.0118857
R930 VSS.n248 VSS.n246 0.0118857
R931 VSS.n246 VSS.n245 0.0118857
R932 VSS.n243 VSS.n242 0.0118857
R933 VSS.n232 VSS.n231 0.0118857
R934 VSS.n230 VSS.n227 0.0118857
R935 VSS.n51 VSS.n227 0.0118857
R936 VSS.n49 VSS.n224 0.0118857
R937 VSS.n224 VSS.n223 0.0118857
R938 VSS.n218 VSS.n215 0.0118857
R939 VSS.n215 VSS.n214 0.0118857
R940 VSS.n213 VSS.n212 0.0118857
R941 VSS.n278 VSS.n209 0.0118857
R942 VSS.n283 VSS.n282 0.0118857
R943 VSS.n288 VSS.n202 0.0118857
R944 VSS.n292 VSS.n290 0.0118857
R945 VSS.n296 VSS.n293 0.0118857
R946 VSS.n304 VSS.n303 0.0118857
R947 VSS.n314 VSS.n313 0.0118857
R948 VSS.n181 VSS.n180 0.0118857
R949 VSS.n174 VSS.n173 0.0118857
R950 VSS.n170 VSS.n168 0.0118857
R951 VSS.n168 VSS.n167 0.0118857
R952 VSS.n414 VSS.n406 0.0115582
R953 VSS.n415 VSS.n414 0.0115582
R954 VSS.n408 VSS.n346 0.0112672
R955 VSS.n46 VSS.n27 0.0112168
R956 VSS.n46 VSS.n28 0.0112168
R957 VSS.n46 VSS.n29 0.0112168
R958 VSS.n46 VSS.n30 0.0112168
R959 VSS.n46 VSS.n31 0.0112168
R960 VSS.n46 VSS.n32 0.0112168
R961 VSS.n46 VSS.n33 0.0112168
R962 VSS.n46 VSS.n34 0.0112168
R963 VSS.n46 VSS.n36 0.0112168
R964 VSS.n46 VSS.n37 0.0112168
R965 VSS.n46 VSS.n38 0.0112168
R966 VSS.n46 VSS.n39 0.0112168
R967 VSS.n46 VSS.n40 0.0112168
R968 VSS.n46 VSS.n41 0.0112168
R969 VSS.n46 VSS.n42 0.0112168
R970 VSS.n46 VSS.n43 0.0112168
R971 VSS.n46 VSS.n44 0.0112168
R972 VSS.n256 VSS.n255 0.0108889
R973 VSS.n260 VSS.n236 0.0108889
R974 VSS.n271 VSS.n270 0.0108889
R975 VSS.n284 VSS.n206 0.0108889
R976 VSS.n297 VSS.n198 0.0108889
R977 VSS.n305 VSS.n195 0.0108889
R978 VSS.n315 VSS.n188 0.0108889
R979 VSS.n324 VSS.n323 0.0108889
R980 VSS.n335 VSS.n334 0.0108889
R981 VSS.n412 VSS.n411 0.0108877
R982 VSS.n416 VSS.n405 0.0108877
R983 VSS.n431 VSS.n429 0.0108877
R984 VSS.n409 VSS.n407 0.0108877
R985 VSS.t46 VSS.n346 0.0101032
R986 VSS.t52 VSS.n346 0.0101032
R987 VSS.n414 VSS.t48 0.00981217
R988 VSS.n414 VSS.t41 0.00981217
R989 VSS.n46 VSS.n35 0.00963963
R990 VSS.n62 VSS.n60 0.0054294
R991 VSS.n65 VSS.n63 0.00936111
R992 VSS.n52 VSS.n50 0.00481859
R993 VSS.n56 VSS.n54 0.00481859
R994 VSS.n127 VSS.n120 0.00798582
R995 VSS.n127 VSS.n121 0.00798582
R996 VSS.n132 VSS.n119 0.00798582
R997 VSS.n129 VSS.n119 0.00798582
R998 VSS.n379 VSS.n363 0.00798582
R999 VSS.n379 VSS.n365 0.00798582
R1000 VSS.n384 VSS.n362 0.00798582
R1001 VSS.n384 VSS.n361 0.00798582
R1002 VSS.n122 VSS.n66 0.0151369
R1003 VSS.n122 VSS.n120 0.00756994
R1004 VSS.n128 VSS.n121 0.00756994
R1005 VSS.n131 VSS.n111 0.00756994
R1006 VSS.n132 VSS.n131 0.00756994
R1007 VSS.n130 VSS.n129 0.00756994
R1008 VSS.n380 VSS.n363 0.00756994
R1009 VSS.n365 VSS.n364 0.00756994
R1010 VSS.n377 VSS.n364 0.00756994
R1011 VSS.n382 VSS.n362 0.00756994
R1012 VSS.n383 VSS.n361 0.00756994
R1013 VSS.n383 VSS.n357 0.00756994
R1014 VSS.n65 VSS.n64 0.00772064
R1015 VSS.n62 VSS.n61 0.00772064
R1016 VSS.n402 VSS.n219 0.00691667
R1017 VSS.t97 VSS.n58 0.00691667
R1018 VSS.n349 VSS.n310 0.00691667
R1019 VSS.n414 VSS.n249 0.00630556
R1020 VSS.n348 VSS.n313 0.00619286
R1021 VSS.n350 VSS.n303 0.00619286
R1022 VSS.n57 VSS.n290 0.00619286
R1023 VSS.n399 VSS.n282 0.00619286
R1024 VSS.n299 VSS.n198 0.00619286
R1025 VSS.n58 VSS.n288 0.00619286
R1026 VSS.n279 VSS.n278 0.00619286
R1027 VSS.n219 VSS.n218 0.00619286
R1028 VSS.n50 VSS.n49 0.0105114
R1029 VSS.n61 VSS.n236 0.00619286
R1030 VSS.n249 VSS.n248 0.00619286
R1031 VSS.n255 VSS.n239 0.00619286
R1032 VSS.n259 VSS.n256 0.00619286
R1033 VSS.n261 VSS.n260 0.00619286
R1034 VSS.n60 VSS.n59 0.0111223
R1035 VSS.n56 VSS.n55 0.00894286
R1036 VSS.t97 VSS.n57 0.00891217
R1037 VSS.n270 VSS.n222 0.00619286
R1038 VSS.n272 VSS.n271 0.00619286
R1039 VSS.n401 VSS.n273 0.00619286
R1040 VSS.n285 VSS.n284 0.00619286
R1041 VSS.n206 VSS.n205 0.00619286
R1042 VSS.n298 VSS.n297 0.00619286
R1043 VSS.n300 VSS.n299 0.00619286
R1044 VSS.n306 VSS.n305 0.00619286
R1045 VSS.n195 VSS.n194 0.00619286
R1046 VSS.n310 VSS.n309 0.00619286
R1047 VSS.n316 VSS.n315 0.00619286
R1048 VSS.n188 VSS.n187 0.00619286
R1049 VSS.n54 VSS.n53 0.0105114
R1050 VSS.n52 VSS.n51 0.00894286
R1051 VSS.n323 VSS.n179 0.00619286
R1052 VSS.n325 VSS.n324 0.00619286
R1053 VSS.n63 VSS.n326 0.00619286
R1054 VSS.n334 VSS.n165 0.00619286
R1055 VSS.n338 VSS.n335 0.00619286
R1056 VSS.n345 VSS.n339 0.00619286
R1057 VSS.n346 VSS.n345 0.00615278
R1058 VSS.n400 VSS.n279 0.00569444
R1059 VSS.n400 VSS.n399 0.00569444
R1060 VSS.n351 VSS.n300 0.00569444
R1061 VSS.n351 VSS.n350 0.00569444
R1062 VSS.n67 VSS.n112 0.00529982
R1063 VSS.n110 VSS.n67 0.00501091
R1064 VSS.n46 VSS.n45 0.00482001
R1065 VSS.n402 VSS.n401 0.00447222
R1066 VSS.n349 VSS.n348 0.00447222
R1067 VSS.n112 VSS.n107 0.00429982
R1068 VSS.n381 VSS.n46 0.00378454
R1069 VSS.n48 VSS.n440 6777.49
R1070 VSS.n342 VSS.n1 1.19504
C0 VDD vin1 26.4431f
C1 VDD vin4 26.4431f
C2 vin3 vout3 15.8261f
C3 vin3 vin2 0.02893f
C4 VDD vout2 9.53933f
C5 vin2 vin1 0.02526f
C6 vin2 vout2 15.8261f
C7 vout3 VDD 9.53933f
C8 VDD vin2 26.4113f
C9 vin4 vout4 15.8261f
C10 vout1 vin1 15.8261f
C11 vin3 vin4 0.02526f
C12 VDD vout4 9.54501f
C13 VDD vout1 9.54501f
C14 vin3 VDD 26.4113f
C15 vout1 VSS 11.09137f
C16 vout2 VSS 11.07377f
C17 vout3 VSS 11.07377f
C18 vout4 VSS 11.09137f
C19 VSS.t105 VSS 6.85365f
C20 VSS.t24 VSS 6.87125f
C21 VSS.t76 VSS 6.85365f
.ends
